# Ansys Electronics Desktop project, version 2024.2
project variables:
  $groundT = 17um
materials:
  air: permittivity=1.0006 permeability=1.0000004
  vacuum: permittivity=1
  pec: conductivity=1e+30
  copper: permittivity=1 permeability=0.999991 conductivity=58000000

design HFSSDesign1 (HFSS, HFSS Hybrid Terminal Network, model units mm)
options: Allow_Material_Override Calculate_Lossy_Dielectrics Save_Adaptive_support_files
geometry:
  airbox [air] = imported_body()
  Polyline1 [copper] = polyline(z=0mm, xy in mm: (-4.3068, 5.7359) (-3.8068, 5.7359) (-3.8068, 4.9359) (-4.3068, 4.9359) (-4.3068, 5.7359), closed, covered)
  Polyline2 [copper] = polyline(z=0mm, xy in mm: (-4.6054, 3.3109) (-4.1054, 3.3109) (-4.1054, 2.5109) (-4.6054, 2.5109) (-4.6054, 3.3109), closed, covered)
  Polyline3 [copper] = polyline(z=0mm, xy in mm: (-3.0068, 5.7359) (-3.0068, 4.9359) (-2.8068, 4.9359) (-2.8068, 4.4359) (-2.0068, 4.4359) (-2.0068, 5.7359) (-3.0068, 5.7359), closed, covered)
  Polyline4 [copper] = polyline(z=0mm, xy in mm: (-1.2068, 5.7359) (-0.0068, 5.7359) (-0.0068, 4.9359) (-1.2068, 4.9359) (-1.2068, 5.7359), closed, covered)
  Polyline5 [copper] = polyline(z=0mm, xy in mm: (-4.6054, 3.3109) (-4.1054, 3.3109) (-4.1054, 2.5109) (-4.6054, 2.5109) (-4.6054, 3.3109), closed, covered)
  Polyline6 [copper] = polyline(z=0mm, xy in mm: (-3.3054, 3.3109) (-2.8068, 3.3109) (-2.8068, 3.6359) (-2.0068, 3.6359) (-2.0068, 3.1359) (-1.8045, 3.1359) (-1.6612, 3.1119) (-1.6612, 2.7119) (-1.8045, 2.6859) (-1.9456967, 2.6859) (-1.7045, 2.2814) (-2.3906, 1.8705) (-2.8054, 2.5109) (-3.3054, 2.5109) (-3.3054, 3.3109), closed, covered)
  Polyline7 [copper] = polyline(z=0mm, xy in mm: (-1.2936, 1.5953) (-1.0386392, 1.1680737) (-0.7796, 1.5979) (-0.0936, 1.1869) (-0.351, 0.7589) (-1.723, 0.7539) (-1.9797, 1.1844) (-1.2936, 1.5953), closed, covered)
  Polyline9 [copper] = polyline(z=0mm, xy in mm: (-1.9797, 1.1844) (-1.2936, 1.5953) (-1.0386392, 1.1680737) (-0.7796, 1.5979) (-0.0936, 1.1869) (-0.351, 0.7589) (-1.723, 0.7539) (-1.9797, 1.1844), closed, covered)
  Polyline10 [copper] = polyline(z=0mm, xy in mm: (-0.4112, 3.1119) (-0.2612, 3.1369) (0.7406, 3.1369) (0.7406, 3.3119) (1.2406, 3.3119) (1.2406, 2.5119) (1.391, 2.5119) (1.391, 2.0119) (0.591, 2.0119) (0.3174, 1.8729) (-0.3686, 2.2839) (-0.1262351, 2.6869) (-0.2612, 2.6869) (-0.4112, 2.7119) (-0.4112, 3.1119), closed, covered)
  Polyline11 [copper] = polyline(z=0mm, xy in mm: (2.0406, 3.3119) (2.5406, 3.3119) (2.5406, 2.5119) (2.0406, 2.5119) (2.0406, 3.3119), closed, covered)
  Polyline12 [copper] = polyline(z=0mm, xy in mm: (0.591, 1.2119) (1.391, 1.2119) (1.391, 0.0147) (0.591, 0.0147) (0.591, 1.2119), closed, covered)
  Rectangle1 [copper] = rectangle(corner=(-0.0068mm, 5.7359mm, 0mm), x_size=-0.7mm, y_size=-0.8mm)
  Rectangle1_1 = Rectangle1.copy()
  Polyline4.subtract(Rectangle1_1)
  Rectangle2 [copper] = rectangle(corner=(0.591mm, 0.0147mm, 0mm), x_size=0.8mm, y_size=0.7mm)
  Rectangle2_1 = Rectangle2.copy()
  Polyline12.subtract(Rectangle2_1)
  [Polyline1, Polyline2].thicken($groundT)
  Polyline3.thicken(-$groundT)
  [Polyline4..Polyline7, Polyline9..Polyline12].thicken($groundT)
  [Rectangle1, Rectangle2].thicken(-$groundT)
  [Polyline1..Polyline7, Polyline9..Polyline12, Rectangle1, Rectangle2].rotate(axis=X, angle=180deg)
  group Group1 = Polyline1..Polyline7, Polyline9..Polyline12, Rectangle1, Rectangle2
boundaries and excitations:
  airbox_RAD: Radiation Objects=airbox
mesh:
  initial mesh: MeshMethod=AnsoftClassic
setups:
  Setup1: HfssDriven Frequency=2.4GHz MaxDeltaE=0.1 MaximumPasses=10 MinimumPasses=1 MinimumConvergedPasses=1 PercentRefinement=30 BasisOrder=-1 Target=0.666667 DrivenSolverType="Direct Solver"
    sweep Sweep1: 0GHz to 5GHz step 0.025GHz; Type=Interpolating InterpTolerance=0.5 InterpMaxSolns=250 MinSolvedFreq=0.025GHz PassivityErrorTolerance=0.0001
